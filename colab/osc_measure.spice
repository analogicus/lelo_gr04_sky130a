* NGSPICE file created from osc_measure.ext - technology: sky130A

* Black-box entry subcircuit for sky130_fd_sc_hd__fill_1 abstract view
.subckt sky130_fd_sc_hd__fill_1 VGND VNB VPB VPWR
.ends

* Black-box entry subcircuit for sky130_fd_sc_hd__fill_2 abstract view
.subckt sky130_fd_sc_hd__fill_2 VGND VNB VPB VPWR
.ends

* Black-box entry subcircuit for sky130_fd_sc_hd__inv_2 abstract view
.subckt sky130_fd_sc_hd__inv_2 A VGND VNB VPB VPWR Y
.ends

* Black-box entry subcircuit for sky130_fd_sc_hd__decap_4 abstract view
.subckt sky130_fd_sc_hd__decap_4 VGND VNB VPB VPWR
.ends

* Black-box entry subcircuit for sky130_fd_sc_hd__a21o_1 abstract view
.subckt sky130_fd_sc_hd__a21o_1 A1 A2 B1 VGND VNB VPB VPWR X
.ends

* Black-box entry subcircuit for sky130_fd_sc_hd__tapvpwrvgnd_1 abstract view
.subckt sky130_fd_sc_hd__tapvpwrvgnd_1 VGND VPWR
.ends

* Black-box entry subcircuit for sky130_fd_sc_hd__buf_2 abstract view
.subckt sky130_fd_sc_hd__buf_2 A VGND VNB VPB VPWR X
.ends

* Black-box entry subcircuit for sky130_fd_sc_hd__decap_3 abstract view
.subckt sky130_fd_sc_hd__decap_3 VGND VNB VPB VPWR
.ends

* Black-box entry subcircuit for sky130_fd_sc_hd__mux2_1 abstract view
.subckt sky130_fd_sc_hd__mux2_1 A0 A1 S VGND VNB VPB VPWR X
.ends

* Black-box entry subcircuit for sky130_fd_sc_hd__decap_8 abstract view
.subckt sky130_fd_sc_hd__decap_8 VGND VNB VPB VPWR
.ends

* Black-box entry subcircuit for sky130_ef_sc_hd__decap_12 abstract view
.subckt sky130_ef_sc_hd__decap_12 VPWR VGND VPB VNB
.ends

* Black-box entry subcircuit for sky130_fd_sc_hd__dlygate4sd3_1 abstract view
.subckt sky130_fd_sc_hd__dlygate4sd3_1 A VGND VNB VPB VPWR X
.ends

* Black-box entry subcircuit for sky130_fd_sc_hd__clkbuf_4 abstract view
.subckt sky130_fd_sc_hd__clkbuf_4 A VGND VNB VPB VPWR X
.ends

* Black-box entry subcircuit for sky130_fd_sc_hd__nor3_1 abstract view
.subckt sky130_fd_sc_hd__nor3_1 A B C VGND VNB VPB VPWR Y
.ends

* Black-box entry subcircuit for sky130_fd_sc_hd__a21oi_1 abstract view
.subckt sky130_fd_sc_hd__a21oi_1 A1 A2 B1 VGND VNB VPB VPWR Y
.ends

* Black-box entry subcircuit for sky130_fd_sc_hd__clkbuf_16 abstract view
.subckt sky130_fd_sc_hd__clkbuf_16 A VGND VNB VPB VPWR X
.ends

* Black-box entry subcircuit for sky130_fd_sc_hd__o21a_1 abstract view
.subckt sky130_fd_sc_hd__o21a_1 A1 A2 B1 VGND VNB VPB VPWR X
.ends

* Black-box entry subcircuit for sky130_fd_sc_hd__dfrtp_4 abstract view
.subckt sky130_fd_sc_hd__dfrtp_4 CLK D RESET_B VGND VNB VPB VPWR Q
.ends

* Black-box entry subcircuit for sky130_fd_sc_hd__nor2_1 abstract view
.subckt sky130_fd_sc_hd__nor2_1 A B VGND VNB VPB VPWR Y
.ends

* Black-box entry subcircuit for sky130_fd_sc_hd__a31o_1 abstract view
.subckt sky130_fd_sc_hd__a31o_1 A1 A2 A3 B1 VGND VNB VPB VPWR X
.ends

* Black-box entry subcircuit for sky130_fd_sc_hd__a21bo_1 abstract view
.subckt sky130_fd_sc_hd__a21bo_1 A1 A2 B1_N VGND VNB VPB VPWR X
.ends

* Black-box entry subcircuit for sky130_fd_sc_hd__dfrtp_1 abstract view
.subckt sky130_fd_sc_hd__dfrtp_1 CLK D RESET_B VGND VNB VPB VPWR Q
.ends

* Black-box entry subcircuit for sky130_fd_sc_hd__and4_1 abstract view
.subckt sky130_fd_sc_hd__and4_1 A B C D VGND VNB VPB VPWR X
.ends

* Black-box entry subcircuit for sky130_fd_sc_hd__or4b_1 abstract view
.subckt sky130_fd_sc_hd__or4b_1 A B C D_N VGND VNB VPB VPWR X
.ends

* Black-box entry subcircuit for sky130_fd_sc_hd__dfstp_1 abstract view
.subckt sky130_fd_sc_hd__dfstp_1 CLK D SET_B VGND VNB VPB VPWR Q
.ends

* Black-box entry subcircuit for sky130_fd_sc_hd__and3_1 abstract view
.subckt sky130_fd_sc_hd__and3_1 A B C VGND VNB VPB VPWR X
.ends

* Black-box entry subcircuit for sky130_fd_sc_hd__clkbuf_2 abstract view
.subckt sky130_fd_sc_hd__clkbuf_2 A VGND VNB VPB VPWR X
.ends

* Black-box entry subcircuit for sky130_fd_sc_hd__clkbuf_1 abstract view
.subckt sky130_fd_sc_hd__clkbuf_1 A VGND VNB VPB VPWR X
.ends

* Black-box entry subcircuit for sky130_fd_sc_hd__buf_1 abstract view
.subckt sky130_fd_sc_hd__buf_1 A VGND VNB VPB VPWR X
.ends

* Black-box entry subcircuit for sky130_fd_sc_hd__dlymetal6s2s_1 abstract view
.subckt sky130_fd_sc_hd__dlymetal6s2s_1 A VGND VNB VPB VPWR X
.ends

* Black-box entry subcircuit for sky130_fd_sc_hd__buf_4 abstract view
.subckt sky130_fd_sc_hd__buf_4 A VGND VNB VPB VPWR X
.ends

* Black-box entry subcircuit for sky130_fd_sc_hd__decap_6 abstract view
.subckt sky130_fd_sc_hd__decap_6 VGND VNB VPB VPWR
.ends

* Black-box entry subcircuit for sky130_fd_sc_hd__o21bai_1 abstract view
.subckt sky130_fd_sc_hd__o21bai_1 A1 A2 B1_N VGND VNB VPB VPWR Y
.ends

* Black-box entry subcircuit for sky130_fd_sc_hd__nand2_1 abstract view
.subckt sky130_fd_sc_hd__nand2_1 A B VGND VNB VPB VPWR Y
.ends

* Black-box entry subcircuit for sky130_fd_sc_hd__a211o_1 abstract view
.subckt sky130_fd_sc_hd__a211o_1 A1 A2 B1 C1 VGND VNB VPB VPWR X
.ends

* Black-box entry subcircuit for sky130_fd_sc_hd__o21ba_1 abstract view
.subckt sky130_fd_sc_hd__o21ba_1 A1 A2 B1_N VGND VNB VPB VPWR X
.ends

* Black-box entry subcircuit for sky130_fd_sc_hd__and4b_1 abstract view
.subckt sky130_fd_sc_hd__and4b_1 A_N B C D VGND VNB VPB VPWR X
.ends

* Black-box entry subcircuit for sky130_fd_sc_hd__dfrtp_2 abstract view
.subckt sky130_fd_sc_hd__dfrtp_2 CLK D RESET_B VGND VNB VPB VPWR Q
.ends

* Black-box entry subcircuit for sky130_fd_sc_hd__and2b_1 abstract view
.subckt sky130_fd_sc_hd__and2b_1 A_N B VGND VNB VPB VPWR X
.ends

* Black-box entry subcircuit for sky130_fd_sc_hd__a41o_1 abstract view
.subckt sky130_fd_sc_hd__a41o_1 A1 A2 A3 A4 B1 VGND VNB VPB VPWR X
.ends

* Black-box entry subcircuit for sky130_fd_sc_hd__and2_1 abstract view
.subckt sky130_fd_sc_hd__and2_1 A B VGND VNB VPB VPWR X
.ends

.subckt osc_measure VGND VPWR clk count_value[0] count_value[1] count_value[2] count_value[3]
+ count_value[4] count_value[5] count_value[6] count_value[7] osc_clk pwrupOsc rst
+ start
XFILLER_9_55 VGND VGND VPWR VPWR sky130_fd_sc_hd__fill_1
XFILLER_9_11 VGND VGND VPWR VPWR sky130_fd_sc_hd__fill_2
X_131_ net17 VGND VGND VPWR VPWR _018_ sky130_fd_sc_hd__inv_2
XFILLER_0_57 VGND VGND VPWR VPWR sky130_fd_sc_hd__decap_4
XFILLER_13_3 VGND VGND VPWR VPWR sky130_fd_sc_hd__fill_1
X_114_ net14 _047_ state\[3\] VGND VGND VPWR VPWR _001_ sky130_fd_sc_hd__a21o_1
XTAP_TAPCELL_ROW_5_56 VGND VPWR sky130_fd_sc_hd__tapvpwrvgnd_1
Xoutput7 net7 VGND VGND VPWR VPWR count_value[3] sky130_fd_sc_hd__buf_2
XFILLER_3_57 VGND VGND VPWR VPWR sky130_fd_sc_hd__decap_4
XPHY_EDGE_ROW_21_Right_21 VGND VGND VPWR VPWR sky130_fd_sc_hd__decap_3
XPHY_EDGE_ROW_12_Right_12 VGND VGND VPWR VPWR sky130_fd_sc_hd__decap_3
X_130_ net17 VGND VGND VPWR VPWR _017_ sky130_fd_sc_hd__inv_2
X_113_ net25 osc_counter\[2\] state\[3\] VGND VGND VPWR VPWR _025_ sky130_fd_sc_hd__mux2_1
XPHY_EDGE_ROW_12_Left_37 VGND VGND VPWR VPWR sky130_fd_sc_hd__decap_3
XFILLER_9_23 VGND VGND VPWR VPWR sky130_fd_sc_hd__fill_2
Xoutput10 net10 VGND VGND VPWR VPWR count_value[6] sky130_fd_sc_hd__buf_2
Xoutput8 net8 VGND VGND VPWR VPWR count_value[4] sky130_fd_sc_hd__buf_2
XTAP_TAPCELL_ROW_15_66 VGND VPWR sky130_fd_sc_hd__tapvpwrvgnd_1
XPHY_EDGE_ROW_6_Right_6 VGND VGND VPWR VPWR sky130_fd_sc_hd__decap_3
XPHY_EDGE_ROW_15_Left_40 VGND VGND VPWR VPWR sky130_fd_sc_hd__decap_3
XPHY_EDGE_ROW_0_Left_25 VGND VGND VPWR VPWR sky130_fd_sc_hd__decap_3
XFILLER_3_47 VGND VGND VPWR VPWR sky130_fd_sc_hd__decap_8
XFILLER_9_57 VGND VGND VPWR VPWR sky130_fd_sc_hd__decap_4
XFILLER_0_15 VPWR VGND VPWR VGND sky130_ef_sc_hd__decap_12
XFILLER_3_3 VGND VGND VPWR VPWR sky130_fd_sc_hd__fill_2
X_112_ net21 osc_counter\[3\] state\[3\] VGND VGND VPWR VPWR _026_ sky130_fd_sc_hd__mux2_1
Xhold10 state\[2\] VGND VGND VPWR VPWR net27 sky130_fd_sc_hd__dlygate4sd3_1
Xoutput9 net9 VGND VGND VPWR VPWR count_value[5] sky130_fd_sc_hd__buf_2
Xoutput11 net11 VGND VGND VPWR VPWR count_value[7] sky130_fd_sc_hd__buf_2
XFILLER_3_26 VGND VGND VPWR VPWR sky130_fd_sc_hd__fill_1
X_111_ net20 osc_counter\[4\] state\[3\] VGND VGND VPWR VPWR _027_ sky130_fd_sc_hd__mux2_1
XFILLER_0_27 VGND VGND VPWR VPWR sky130_fd_sc_hd__fill_1
Xoutput12 net12 VGND VGND VPWR VPWR pwrupOsc sky130_fd_sc_hd__buf_2
XFILLER_20_7 VGND VGND VPWR VPWR sky130_fd_sc_hd__fill_1
Xhold11 net12 VGND VGND VPWR VPWR net28 sky130_fd_sc_hd__dlygate4sd3_1
XFILLER_15_35 VGND VGND VPWR VPWR sky130_fd_sc_hd__fill_1
XFILLER_6_26 VGND VGND VPWR VPWR sky130_fd_sc_hd__fill_2
XFILLER_23_57 VGND VGND VPWR VPWR sky130_fd_sc_hd__fill_1
XTAP_TAPCELL_ROW_8_59 VGND VPWR sky130_fd_sc_hd__tapvpwrvgnd_1
X_110_ net24 osc_counter\[5\] state\[3\] VGND VGND VPWR VPWR _028_ sky130_fd_sc_hd__mux2_1
Xclkload0 clknet_1_0__leaf_clk VGND VGND VPWR VPWR clkload0/X sky130_fd_sc_hd__clkbuf_4
XPHY_EDGE_ROW_19_Right_19 VGND VGND VPWR VPWR sky130_fd_sc_hd__decap_3
XPHY_EDGE_ROW_19_Left_44 VGND VGND VPWR VPWR sky130_fd_sc_hd__decap_3
XFILLER_12_37 VGND VGND VPWR VPWR sky130_fd_sc_hd__decap_3
XTAP_TAPCELL_ROW_18_69 VGND VPWR sky130_fd_sc_hd__tapvpwrvgnd_1
XFILLER_9_38 VGND VGND VPWR VPWR sky130_fd_sc_hd__fill_2
XFILLER_1_3 VPWR VGND VPWR VGND sky130_ef_sc_hd__decap_12
XTAP_TAPCELL_ROW_0_50 VGND VPWR sky130_fd_sc_hd__tapvpwrvgnd_1
XFILLER_0_29 VPWR VGND VPWR VGND sky130_ef_sc_hd__decap_12
XPHY_EDGE_ROW_4_Left_29 VGND VGND VPWR VPWR sky130_fd_sc_hd__decap_3
XFILLER_1_61 VGND VGND VPWR VPWR sky130_fd_sc_hd__fill_1
XPHY_EDGE_ROW_7_Left_32 VGND VGND VPWR VPWR sky130_fd_sc_hd__decap_3
XPHY_EDGE_ROW_20_Left_45 VGND VGND VPWR VPWR sky130_fd_sc_hd__decap_3
XFILLER_12_27 VGND VGND VPWR VPWR sky130_fd_sc_hd__fill_1
XFILLER_4_50 VPWR VGND VPWR VGND sky130_ef_sc_hd__decap_12
XFILLER_18_26 VGND VGND VPWR VPWR sky130_fd_sc_hd__fill_2
XTAP_TAPCELL_ROW_9_60 VGND VPWR sky130_fd_sc_hd__tapvpwrvgnd_1
X_099_ net13 _053_ _068_ VGND VGND VPWR VPWR _036_ sky130_fd_sc_hd__nor3_1
XTAP_TAPCELL_ROW_0_51 VGND VPWR sky130_fd_sc_hd__tapvpwrvgnd_1
XFILLER_11_6 VGND VGND VPWR VPWR sky130_fd_sc_hd__fill_2
XPHY_EDGE_ROW_1_Right_1 VGND VGND VPWR VPWR sky130_fd_sc_hd__decap_3
XFILLER_6_18 VGND VGND VPWR VPWR sky130_fd_sc_hd__fill_1
XFILLER_6_29 VPWR VGND VPWR VGND sky130_ef_sc_hd__decap_12
XFILLER_7_61 VGND VGND VPWR VPWR sky130_fd_sc_hd__fill_1
XTAP_TAPCELL_ROW_19_70 VGND VPWR sky130_fd_sc_hd__tapvpwrvgnd_1
XFILLER_10_61 VGND VGND VPWR VPWR sky130_fd_sc_hd__fill_1
XTAP_TAPCELL_ROW_10_61 VGND VPWR sky130_fd_sc_hd__tapvpwrvgnd_1
X_098_ osc_counter\[2\] _052_ osc_counter\[3\] VGND VGND VPWR VPWR _068_ sky130_fd_sc_hd__a21oi_1
XPHY_EDGE_ROW_24_Right_24 VGND VGND VPWR VPWR sky130_fd_sc_hd__decap_3
Xclkbuf_0_clk clk VGND VGND VPWR VPWR clknet_0_clk sky130_fd_sc_hd__clkbuf_16
XFILLER_16_60 VGND VGND VPWR VPWR sky130_fd_sc_hd__fill_2
XPHY_EDGE_ROW_15_Right_15 VGND VGND VPWR VPWR sky130_fd_sc_hd__decap_3
XFILLER_13_61 VGND VGND VPWR VPWR sky130_fd_sc_hd__fill_1
XFILLER_1_31 VGND VGND VPWR VPWR sky130_fd_sc_hd__fill_1
XFILLER_1_42 VPWR VGND VPWR VGND sky130_ef_sc_hd__decap_12
X_097_ osc_counter\[4\] _053_ _067_ VGND VGND VPWR VPWR _037_ sky130_fd_sc_hd__o21a_1
XTAP_TAPCELL_ROW_21_72 VGND VPWR sky130_fd_sc_hd__tapvpwrvgnd_1
XFILLER_21_61 VGND VGND VPWR VPWR sky130_fd_sc_hd__fill_1
XFILLER_19_60 VGND VGND VPWR VPWR sky130_fd_sc_hd__fill_2
X_149_ clknet_1_0__leaf_clk net18 _013_ VGND VGND VPWR VPWR state\[3\] sky130_fd_sc_hd__dfrtp_4
XFILLER_10_40 VGND VGND VPWR VPWR sky130_fd_sc_hd__fill_2
XPHY_EDGE_ROW_24_Left_49 VGND VGND VPWR VPWR sky130_fd_sc_hd__decap_3
XFILLER_18_29 VGND VGND VPWR VPWR sky130_fd_sc_hd__fill_2
XFILLER_24_61 VGND VGND VPWR VPWR sky130_fd_sc_hd__fill_1
X_148_ clknet_1_0__leaf_clk _000_ _012_ VGND VGND VPWR VPWR state\[2\] sky130_fd_sc_hd__dfrtp_4
XFILLER_1_54 VGND VGND VPWR VPWR sky130_fd_sc_hd__fill_2
X_096_ net13 _054_ VGND VGND VPWR VPWR _067_ sky130_fd_sc_hd__nor2_1
XPHY_EDGE_ROW_11_Left_36 VGND VGND VPWR VPWR sky130_fd_sc_hd__decap_3
X_079_ osc_counter\[8\] _051_ _054_ osc_counter\[9\] VGND VGND VPWR VPWR _055_ sky130_fd_sc_hd__a31o_1
XPHY_EDGE_ROW_5_Right_5 VGND VGND VPWR VPWR sky130_fd_sc_hd__decap_3
XTAP_TAPCELL_ROW_3_54 VGND VPWR sky130_fd_sc_hd__tapvpwrvgnd_1
X_095_ osc_counter\[5\] _064_ _066_ VGND VGND VPWR VPWR _038_ sky130_fd_sc_hd__a21bo_1
X_147_ clknet_1_0__leaf_clk net27 _011_ VGND VGND VPWR VPWR state\[1\] sky130_fd_sc_hd__dfrtp_1
X_078_ osc_counter\[4\] osc_counter\[3\] osc_counter\[2\] _052_ VGND VGND VPWR VPWR
+ _054_ sky130_fd_sc_hd__and4_1
XPHY_EDGE_ROW_20_Right_20 VGND VGND VPWR VPWR sky130_fd_sc_hd__decap_3
XPHY_EDGE_ROW_11_Right_11 VGND VGND VPWR VPWR sky130_fd_sc_hd__decap_3
XTAP_TAPCELL_ROW_13_64 VGND VPWR sky130_fd_sc_hd__tapvpwrvgnd_1
XFILLER_4_11 VGND VGND VPWR VPWR sky130_fd_sc_hd__fill_1
XFILLER_4_22 VGND VGND VPWR VPWR sky130_fd_sc_hd__fill_2
X_094_ osc_counter\[5\] net14 _057_ _050_ VGND VGND VPWR VPWR _066_ sky130_fd_sc_hd__or4b_1
X_146_ clknet_1_0__leaf_clk _001_ _010_ VGND VGND VPWR VPWR state\[0\] sky130_fd_sc_hd__dfstp_1
X_077_ osc_counter\[3\] osc_counter\[2\] _052_ VGND VGND VPWR VPWR _053_ sky130_fd_sc_hd__and3_1
X_129_ net17 VGND VGND VPWR VPWR _016_ sky130_fd_sc_hd__inv_2
XTAP_TAPCELL_ROW_24_75 VGND VPWR sky130_fd_sc_hd__tapvpwrvgnd_1
X_093_ osc_counter\[6\] _064_ _065_ VGND VGND VPWR VPWR _039_ sky130_fd_sc_hd__a21bo_1
XFILLER_8_3 VGND VGND VPWR VPWR sky130_fd_sc_hd__fill_2
X_145_ clknet_1_1__leaf_clk _032_ _009_ VGND VGND VPWR VPWR net11 sky130_fd_sc_hd__dfrtp_1
Xinput1 osc_clk VGND VGND VPWR VPWR net1 sky130_fd_sc_hd__clkbuf_2
X_076_ osc_counter\[1\] osc_counter\[0\] state\[2\] VGND VGND VPWR VPWR _052_ sky130_fd_sc_hd__and3_1
XFILLER_1_35 VGND VGND VPWR VPWR sky130_fd_sc_hd__decap_4
XFILLER_1_57 VGND VGND VPWR VPWR sky130_fd_sc_hd__decap_4
XFILLER_23_3 VGND VGND VPWR VPWR sky130_fd_sc_hd__fill_2
XFILLER_16_43 VGND VGND VPWR VPWR sky130_fd_sc_hd__fill_2
XPHY_EDGE_ROW_9_Right_9 VGND VGND VPWR VPWR sky130_fd_sc_hd__decap_3
X_128_ net17 VGND VGND VPWR VPWR _015_ sky130_fd_sc_hd__inv_2
XPHY_EDGE_ROW_18_Left_43 VGND VGND VPWR VPWR sky130_fd_sc_hd__decap_3
XTAP_TAPCELL_ROW_24_76 VGND VPWR sky130_fd_sc_hd__tapvpwrvgnd_1
X_092_ osc_counter\[6\] net14 _057_ _062_ VGND VGND VPWR VPWR _065_ sky130_fd_sc_hd__or4b_1
XFILLER_10_45 VPWR VGND VPWR VGND sky130_ef_sc_hd__decap_12
Xinput2 rst VGND VGND VPWR VPWR net2 sky130_fd_sc_hd__clkbuf_1
XPHY_EDGE_ROW_3_Left_28 VGND VGND VPWR VPWR sky130_fd_sc_hd__decap_3
X_144_ clknet_1_1__leaf_clk _031_ _008_ VGND VGND VPWR VPWR net10 sky130_fd_sc_hd__dfrtp_1
X_075_ osc_counter\[7\] osc_counter\[6\] osc_counter\[5\] VGND VGND VPWR VPWR _051_
+ sky130_fd_sc_hd__and3_1
X_127_ net17 VGND VGND VPWR VPWR _014_ sky130_fd_sc_hd__inv_2
XPHY_EDGE_ROW_6_Left_31 VGND VGND VPWR VPWR sky130_fd_sc_hd__decap_3
XFILLER_7_35 VGND VGND VPWR VPWR sky130_fd_sc_hd__fill_1
XTAP_TAPCELL_ROW_6_57 VGND VPWR sky130_fd_sc_hd__tapvpwrvgnd_1
XFILLER_7_57 VGND VGND VPWR VPWR sky130_fd_sc_hd__decap_4
XFILLER_13_34 VGND VGND VPWR VPWR sky130_fd_sc_hd__fill_2
Xfanout13 state\[0\] VGND VGND VPWR VPWR net13 sky130_fd_sc_hd__buf_2
XFILLER_24_55 VGND VGND VPWR VPWR sky130_fd_sc_hd__fill_1
X_143_ clknet_1_1__leaf_clk _030_ _007_ VGND VGND VPWR VPWR net9 sky130_fd_sc_hd__dfrtp_1
XPHY_EDGE_ROW_18_Right_18 VGND VGND VPWR VPWR sky130_fd_sc_hd__decap_3
X_160_ clknet_1_0__leaf_clk _043_ _024_ VGND VGND VPWR VPWR net12 sky130_fd_sc_hd__dfrtp_1
X_091_ state\[2\] _062_ net13 VGND VGND VPWR VPWR _064_ sky130_fd_sc_hd__a21oi_1
XFILLER_10_57 VGND VGND VPWR VPWR sky130_fd_sc_hd__decap_4
X_074_ osc_counter\[4\] osc_counter\[0\] _049_ VGND VGND VPWR VPWR _050_ sky130_fd_sc_hd__and3_1
Xinput3 start VGND VGND VPWR VPWR net3 sky130_fd_sc_hd__buf_1
XFILLER_1_15 VGND VGND VPWR VPWR sky130_fd_sc_hd__decap_8
X_126_ net15 VGND VGND VPWR VPWR _013_ sky130_fd_sc_hd__inv_2
XTAP_TAPCELL_ROW_16_67 VGND VPWR sky130_fd_sc_hd__tapvpwrvgnd_1
XFILLER_16_23 VGND VGND VPWR VPWR sky130_fd_sc_hd__fill_1
XPHY_EDGE_ROW_0_Right_0 VGND VGND VPWR VPWR sky130_fd_sc_hd__decap_3
X_109_ net26 osc_counter\[6\] state\[3\] VGND VGND VPWR VPWR _029_ sky130_fd_sc_hd__mux2_1
Xfanout14 state\[0\] VGND VGND VPWR VPWR net14 sky130_fd_sc_hd__dlymetal6s2s_1
X_090_ _060_ _061_ _063_ VGND VGND VPWR VPWR _040_ sky130_fd_sc_hd__a21oi_1
XFILLER_1_27 VGND VGND VPWR VPWR sky130_fd_sc_hd__decap_4
XFILLER_6_3 VGND VGND VPWR VPWR sky130_fd_sc_hd__decap_8
X_142_ clknet_1_1__leaf_clk _029_ _006_ VGND VGND VPWR VPWR net8 sky130_fd_sc_hd__dfrtp_1
XFILLER_19_23 VGND VGND VPWR VPWR sky130_fd_sc_hd__fill_1
X_125_ net17 VGND VGND VPWR VPWR _012_ sky130_fd_sc_hd__inv_2
X_073_ osc_counter\[3\] osc_counter\[2\] osc_counter\[1\] VGND VGND VPWR VPWR _049_
+ sky130_fd_sc_hd__and3_1
X_108_ net19 osc_counter\[7\] state\[3\] VGND VGND VPWR VPWR _030_ sky130_fd_sc_hd__mux2_1
XFILLER_16_35 VGND VGND VPWR VPWR sky130_fd_sc_hd__decap_8
Xfanout15 net17 VGND VGND VPWR VPWR net15 sky130_fd_sc_hd__buf_4
XFILLER_4_38 VPWR VGND VPWR VGND sky130_ef_sc_hd__decap_12
X_141_ clknet_1_1__leaf_clk _028_ _005_ VGND VGND VPWR VPWR net7 sky130_fd_sc_hd__dfrtp_1
X_072_ net28 state\[2\] _048_ VGND VGND VPWR VPWR _043_ sky130_fd_sc_hd__o21a_1
X_124_ net15 VGND VGND VPWR VPWR _011_ sky130_fd_sc_hd__inv_2
X_107_ net23 osc_counter\[8\] state\[3\] VGND VGND VPWR VPWR _031_ sky130_fd_sc_hd__mux2_1
Xfanout16 net17 VGND VGND VPWR VPWR net16 sky130_fd_sc_hd__clkbuf_2
XPHY_EDGE_ROW_23_Left_48 VGND VGND VPWR VPWR sky130_fd_sc_hd__decap_3
XFILLER_5_60 VGND VGND VPWR VPWR sky130_fd_sc_hd__fill_2
XPHY_EDGE_ROW_23_Right_23 VGND VGND VPWR VPWR sky130_fd_sc_hd__decap_3
X_140_ clknet_1_1__leaf_clk _027_ _004_ VGND VGND VPWR VPWR net6 sky130_fd_sc_hd__dfrtp_1
XFILLER_21_15 VGND VGND VPWR VPWR sky130_fd_sc_hd__fill_1
XPHY_EDGE_ROW_14_Right_14 VGND VGND VPWR VPWR sky130_fd_sc_hd__decap_3
X_071_ net14 net18 VGND VGND VPWR VPWR _048_ sky130_fd_sc_hd__nor2_1
XFILLER_2_61 VGND VGND VPWR VPWR sky130_fd_sc_hd__fill_1
X_106_ net22 osc_counter\[9\] state\[3\] VGND VGND VPWR VPWR _032_ sky130_fd_sc_hd__mux2_1
XFILLER_16_48 VPWR VGND VPWR VGND sky130_ef_sc_hd__decap_12
XPHY_EDGE_ROW_10_Left_35 VGND VGND VPWR VPWR sky130_fd_sc_hd__decap_3
X_123_ net15 VGND VGND VPWR VPWR _010_ sky130_fd_sc_hd__inv_2
XPHY_EDGE_ROW_4_Right_4 VGND VGND VPWR VPWR sky130_fd_sc_hd__decap_3
Xfanout17 net2 VGND VGND VPWR VPWR net17 sky130_fd_sc_hd__buf_4
XFILLER_24_26 VGND VGND VPWR VPWR sky130_fd_sc_hd__fill_2
X_070_ net15 VGND VGND VPWR VPWR _002_ sky130_fd_sc_hd__inv_2
XFILLER_4_3 VGND VGND VPWR VPWR sky130_fd_sc_hd__decap_8
X_122_ net16 VGND VGND VPWR VPWR _009_ sky130_fd_sc_hd__inv_2
XFILLER_16_27 VGND VGND VPWR VPWR sky130_fd_sc_hd__fill_1
XFILLER_11_60 VGND VGND VPWR VPWR sky130_fd_sc_hd__fill_2
XFILLER_7_29 VGND VGND VPWR VPWR sky130_fd_sc_hd__decap_6
X_105_ osc_counter\[0\] state\[2\] _046_ VGND VGND VPWR VPWR _033_ sky130_fd_sc_hd__o21a_1
XTAP_TAPCELL_ROW_1_52 VGND VPWR sky130_fd_sc_hd__tapvpwrvgnd_1
X_121_ net16 VGND VGND VPWR VPWR _008_ sky130_fd_sc_hd__inv_2
Xclkbuf_1_0__f_clk clknet_0_clk VGND VGND VPWR VPWR clknet_1_0__leaf_clk sky130_fd_sc_hd__clkbuf_16
X_104_ osc_counter\[0\] state\[2\] net13 VGND VGND VPWR VPWR _046_ sky130_fd_sc_hd__a21oi_1
X_120_ net16 VGND VGND VPWR VPWR _007_ sky130_fd_sc_hd__inv_2
XTAP_TAPCELL_ROW_11_62 VGND VPWR sky130_fd_sc_hd__tapvpwrvgnd_1
XFILLER_11_40 VGND VGND VPWR VPWR sky130_fd_sc_hd__fill_1
XPHY_EDGE_ROW_10_Right_10 VGND VGND VPWR VPWR sky130_fd_sc_hd__decap_3
XFILLER_17_61 VGND VGND VPWR VPWR sky130_fd_sc_hd__fill_1
XPHY_EDGE_ROW_14_Left_39 VGND VGND VPWR VPWR sky130_fd_sc_hd__decap_3
X_103_ net13 _052_ _045_ VGND VGND VPWR VPWR _034_ sky130_fd_sc_hd__nor3_1
XFILLER_24_29 VGND VGND VPWR VPWR sky130_fd_sc_hd__fill_1
XPHY_EDGE_ROW_17_Left_42 VGND VGND VPWR VPWR sky130_fd_sc_hd__decap_3
Xhold1 state\[1\] VGND VGND VPWR VPWR net18 sky130_fd_sc_hd__dlygate4sd3_1
XPHY_EDGE_ROW_8_Right_8 VGND VGND VPWR VPWR sky130_fd_sc_hd__decap_3
XPHY_EDGE_ROW_2_Left_27 VGND VGND VPWR VPWR sky130_fd_sc_hd__decap_3
XTAP_TAPCELL_ROW_22_73 VGND VPWR sky130_fd_sc_hd__tapvpwrvgnd_1
XPHY_EDGE_ROW_5_Left_30 VGND VGND VPWR VPWR sky130_fd_sc_hd__decap_3
X_102_ osc_counter\[0\] state\[2\] osc_counter\[1\] VGND VGND VPWR VPWR _045_ sky130_fd_sc_hd__a21oi_1
Xhold2 net9 VGND VGND VPWR VPWR net19 sky130_fd_sc_hd__dlygate4sd3_1
XFILLER_5_43 VGND VGND VPWR VPWR sky130_fd_sc_hd__fill_1
XFILLER_5_54 VGND VGND VPWR VPWR sky130_fd_sc_hd__fill_2
X_101_ osc_counter\[2\] _052_ _044_ VGND VGND VPWR VPWR _035_ sky130_fd_sc_hd__a21oi_1
Xhold3 net6 VGND VGND VPWR VPWR net20 sky130_fd_sc_hd__dlygate4sd3_1
XFILLER_10_3 VGND VGND VPWR VPWR sky130_fd_sc_hd__fill_2
XTAP_TAPCELL_ROW_4_55 VGND VPWR sky130_fd_sc_hd__tapvpwrvgnd_1
XFILLER_11_54 VGND VGND VPWR VPWR sky130_fd_sc_hd__fill_2
X_100_ osc_counter\[2\] _052_ net13 VGND VGND VPWR VPWR _044_ sky130_fd_sc_hd__o21bai_1
Xhold4 net5 VGND VGND VPWR VPWR net21 sky130_fd_sc_hd__dlygate4sd3_1
XFILLER_17_53 VGND VGND VPWR VPWR sky130_fd_sc_hd__decap_3
XPHY_EDGE_ROW_17_Right_17 VGND VGND VPWR VPWR sky130_fd_sc_hd__decap_3
XTAP_TAPCELL_ROW_14_65 VGND VPWR sky130_fd_sc_hd__tapvpwrvgnd_1
XFILLER_11_22 VGND VGND VPWR VPWR sky130_fd_sc_hd__fill_2
XFILLER_2_6 VGND VGND VPWR VPWR sky130_fd_sc_hd__decap_8
XFILLER_8_34 VGND VGND VPWR VPWR sky130_fd_sc_hd__fill_2
XFILLER_0_3 VPWR VGND VPWR VGND sky130_ef_sc_hd__decap_12
X_159_ net1 _042_ _023_ VGND VGND VPWR VPWR osc_counter\[9\] sky130_fd_sc_hd__dfrtp_1
Xhold5 net11 VGND VGND VPWR VPWR net22 sky130_fd_sc_hd__dlygate4sd3_1
XPHY_EDGE_ROW_9_Left_34 VGND VGND VPWR VPWR sky130_fd_sc_hd__decap_3
XFILLER_5_35 VGND VGND VPWR VPWR sky130_fd_sc_hd__decap_8
XPHY_EDGE_ROW_22_Left_47 VGND VGND VPWR VPWR sky130_fd_sc_hd__decap_3
Xhold6 net10 VGND VGND VPWR VPWR net23 sky130_fd_sc_hd__dlygate4sd3_1
X_089_ osc_counter\[6\] _062_ osc_counter\[7\] VGND VGND VPWR VPWR _063_ sky130_fd_sc_hd__a21oi_1
X_158_ net1 _041_ _022_ VGND VGND VPWR VPWR osc_counter\[8\] sky130_fd_sc_hd__dfrtp_1
Xclkbuf_1_1__f_clk clknet_0_clk VGND VGND VPWR VPWR clknet_1_1__leaf_clk sky130_fd_sc_hd__clkbuf_16
XPHY_EDGE_ROW_3_Right_3 VGND VGND VPWR VPWR sky130_fd_sc_hd__decap_3
XFILLER_22_23 VGND VGND VPWR VPWR sky130_fd_sc_hd__fill_1
X_157_ net1 _040_ _021_ VGND VGND VPWR VPWR osc_counter\[7\] sky130_fd_sc_hd__dfrtp_1
X_088_ osc_counter\[5\] osc_counter\[4\] osc_counter\[0\] _049_ VGND VGND VPWR VPWR
+ _062_ sky130_fd_sc_hd__and4_1
XFILLER_8_58 VGND VGND VPWR VPWR sky130_fd_sc_hd__decap_4
XTAP_TAPCELL_ROW_7_58 VGND VPWR sky130_fd_sc_hd__tapvpwrvgnd_1
Xhold7 net7 VGND VGND VPWR VPWR net24 sky130_fd_sc_hd__dlygate4sd3_1
XFILLER_17_45 VGND VGND VPWR VPWR sky130_fd_sc_hd__decap_8
XFILLER_17_12 VGND VGND VPWR VPWR sky130_fd_sc_hd__fill_1
XFILLER_5_15 VPWR VGND VPWR VGND sky130_ef_sc_hd__decap_12
XPHY_EDGE_ROW_22_Right_22 VGND VGND VPWR VPWR sky130_fd_sc_hd__decap_3
XPHY_EDGE_ROW_13_Right_13 VGND VGND VPWR VPWR sky130_fd_sc_hd__decap_3
XFILLER_2_49 VPWR VGND VPWR VGND sky130_ef_sc_hd__decap_12
Xhold8 net4 VGND VGND VPWR VPWR net25 sky130_fd_sc_hd__dlygate4sd3_1
XTAP_TAPCELL_ROW_17_68 VGND VPWR sky130_fd_sc_hd__tapvpwrvgnd_1
XFILLER_17_57 VGND VGND VPWR VPWR sky130_fd_sc_hd__decap_4
X_156_ net1 _039_ _020_ VGND VGND VPWR VPWR osc_counter\[6\] sky130_fd_sc_hd__dfrtp_1
X_087_ osc_counter\[7\] _057_ VGND VGND VPWR VPWR _061_ sky130_fd_sc_hd__nand2_1
X_139_ clknet_1_1__leaf_clk _026_ _003_ VGND VGND VPWR VPWR net5 sky130_fd_sc_hd__dfrtp_1
XFILLER_5_27 VGND VGND VPWR VPWR sky130_fd_sc_hd__fill_1
XFILLER_9_3 VGND VGND VPWR VPWR sky130_fd_sc_hd__fill_2
X_155_ net1 _038_ _019_ VGND VGND VPWR VPWR osc_counter\[5\] sky130_fd_sc_hd__dfrtp_1
X_086_ _050_ _051_ _057_ net14 VGND VGND VPWR VPWR _060_ sky130_fd_sc_hd__a211o_1
XFILLER_24_3 VGND VGND VPWR VPWR sky130_fd_sc_hd__fill_2
Xhold9 net8 VGND VGND VPWR VPWR net26 sky130_fd_sc_hd__dlygate4sd3_1
X_138_ clknet_1_0__leaf_clk _025_ _002_ VGND VGND VPWR VPWR net4 sky130_fd_sc_hd__dfrtp_1
XPHY_EDGE_ROW_13_Left_38 VGND VGND VPWR VPWR sky130_fd_sc_hd__decap_3
X_069_ net3 VGND VGND VPWR VPWR _047_ sky130_fd_sc_hd__inv_2
XFILLER_0_61 VGND VGND VPWR VPWR sky130_fd_sc_hd__fill_1
XFILLER_14_26 VGND VGND VPWR VPWR sky130_fd_sc_hd__fill_2
XPHY_EDGE_ROW_7_Right_7 VGND VGND VPWR VPWR sky130_fd_sc_hd__decap_3
XPHY_EDGE_ROW_16_Left_41 VGND VGND VPWR VPWR sky130_fd_sc_hd__decap_3
XPHY_EDGE_ROW_1_Left_26 VGND VGND VPWR VPWR sky130_fd_sc_hd__decap_3
X_085_ osc_counter\[8\] _058_ _059_ VGND VGND VPWR VPWR _041_ sky130_fd_sc_hd__o21ba_1
X_154_ net1 _037_ _018_ VGND VGND VPWR VPWR osc_counter\[4\] sky130_fd_sc_hd__dfrtp_1
XFILLER_3_61 VGND VGND VPWR VPWR sky130_fd_sc_hd__fill_1
X_137_ net15 VGND VGND VPWR VPWR _024_ sky130_fd_sc_hd__inv_2
XFILLER_6_61 VGND VGND VPWR VPWR sky130_fd_sc_hd__fill_1
XFILLER_12_60 VGND VGND VPWR VPWR sky130_fd_sc_hd__fill_2
XFILLER_9_61 VGND VGND VPWR VPWR sky130_fd_sc_hd__fill_1
XFILLER_0_41 VPWR VGND VPWR VGND sky130_ef_sc_hd__decap_12
X_153_ net1 _036_ _017_ VGND VGND VPWR VPWR osc_counter\[3\] sky130_fd_sc_hd__dfrtp_1
X_084_ osc_counter\[8\] _051_ _054_ net13 VGND VGND VPWR VPWR _059_ sky130_fd_sc_hd__a31o_1
X_136_ net17 VGND VGND VPWR VPWR _023_ sky130_fd_sc_hd__inv_2
XTAP_TAPCELL_ROW_20_71 VGND VPWR sky130_fd_sc_hd__tapvpwrvgnd_1
X_119_ net16 VGND VGND VPWR VPWR _006_ sky130_fd_sc_hd__inv_2
XFILLER_15_60 VGND VGND VPWR VPWR sky130_fd_sc_hd__fill_2
XFILLER_7_3 VGND VGND VPWR VPWR sky130_fd_sc_hd__decap_6
X_083_ net13 state\[2\] _050_ _051_ VGND VGND VPWR VPWR _058_ sky130_fd_sc_hd__and4b_1
X_152_ net1 _035_ _016_ VGND VGND VPWR VPWR osc_counter\[2\] sky130_fd_sc_hd__dfrtp_2
X_118_ net16 VGND VGND VPWR VPWR _005_ sky130_fd_sc_hd__inv_2
XFILLER_0_53 VGND VGND VPWR VPWR sky130_fd_sc_hd__decap_3
X_135_ net17 VGND VGND VPWR VPWR _022_ sky130_fd_sc_hd__inv_2
XFILLER_14_29 VGND VGND VPWR VPWR sky130_fd_sc_hd__fill_1
XTAP_TAPCELL_ROW_2_53 VGND VPWR sky130_fd_sc_hd__tapvpwrvgnd_1
X_134_ net15 VGND VGND VPWR VPWR _021_ sky130_fd_sc_hd__inv_2
X_082_ net13 state\[2\] VGND VGND VPWR VPWR _057_ sky130_fd_sc_hd__nor2_1
XFILLER_9_30 VGND VGND VPWR VPWR sky130_fd_sc_hd__decap_3
X_151_ net1 _034_ _015_ VGND VGND VPWR VPWR osc_counter\[1\] sky130_fd_sc_hd__dfrtp_1
X_117_ net15 VGND VGND VPWR VPWR _004_ sky130_fd_sc_hd__inv_2
XFILLER_18_50 VGND VGND VPWR VPWR sky130_fd_sc_hd__decap_4
XFILLER_15_3 VGND VGND VPWR VPWR sky130_fd_sc_hd__fill_1
XPHY_EDGE_ROW_8_Left_33 VGND VGND VPWR VPWR sky130_fd_sc_hd__decap_3
Xoutput4 net4 VGND VGND VPWR VPWR count_value[0] sky130_fd_sc_hd__buf_2
XPHY_EDGE_ROW_21_Left_46 VGND VGND VPWR VPWR sky130_fd_sc_hd__decap_3
XPHY_EDGE_ROW_16_Right_16 VGND VGND VPWR VPWR sky130_fd_sc_hd__decap_3
XTAP_TAPCELL_ROW_12_63 VGND VPWR sky130_fd_sc_hd__tapvpwrvgnd_1
X_081_ _056_ _055_ VGND VGND VPWR VPWR _042_ sky130_fd_sc_hd__and2b_1
X_150_ net1 _033_ _014_ VGND VGND VPWR VPWR osc_counter\[0\] sky130_fd_sc_hd__dfrtp_1
X_133_ net15 VGND VGND VPWR VPWR _020_ sky130_fd_sc_hd__inv_2
X_116_ net15 VGND VGND VPWR VPWR _003_ sky130_fd_sc_hd__inv_2
XPHY_EDGE_ROW_2_Right_2 VGND VGND VPWR VPWR sky130_fd_sc_hd__decap_3
Xoutput5 net5 VGND VGND VPWR VPWR count_value[1] sky130_fd_sc_hd__buf_2
XFILLER_3_55 VGND VGND VPWR VPWR sky130_fd_sc_hd__fill_1
XTAP_TAPCELL_ROW_23_74 VGND VPWR sky130_fd_sc_hd__tapvpwrvgnd_1
X_132_ net15 VGND VGND VPWR VPWR _019_ sky130_fd_sc_hd__inv_2
X_080_ osc_counter\[9\] osc_counter\[8\] _051_ _054_ net13 VGND VGND VPWR VPWR _056_
+ sky130_fd_sc_hd__a41o_1
XFILLER_5_3 VPWR VGND VPWR VGND sky130_ef_sc_hd__decap_12
X_115_ net14 net3 VGND VGND VPWR VPWR _000_ sky130_fd_sc_hd__and2_1
Xoutput6 net6 VGND VGND VPWR VPWR count_value[2] sky130_fd_sc_hd__buf_2
XFILLER_6_11 VGND VGND VPWR VPWR sky130_fd_sc_hd__decap_3
.ends
